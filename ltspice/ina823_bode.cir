* GEL-7072 Laboratoire 4 - Question 6.2
* Diagramme de Bode de l'INA823 (modele TI) selon l'approche systemique
*   Mode differentiel : V(OUT_D) / (V(POS_D) - V(NEG_D))
*   Mode commun      : V(OUT_C) / ((V(POS_C) + V(NEG_C)) / 2)
*   TRMC (dB)        : 20*log10(abs(Ad/Acm))
* Alimentation BioBLU : AVCC = 3,3 V, AGND = 0 V, REF = 1,65 V
* RG = 2 x 5,6 k = 11,2 k  ->  G1 = 1 + 100k/11,2k = 9,93 V/V

.lib modeles/INA823.LIB

V_AVCC AVCC 0 3.3
V_REF REF 0 1.65

* Mode differentiel : +0,5 V et -0,5 V AC autour de REF
V_PD POS_D REF AC 0.5 0
V_ND NEG_D REF AC 0.5 180
XU_D POS_D NEG_D AVCC 0 OUT_D REF RGP_D RGN_D INA823
R_GD1 RGP_D RGM_D 5.6k
R_GD2 RGM_D RGN_D 5.6k

* Mode commun : 1 V AC sur les deux entrees
V_CM POS_C REF AC 1 0
V_NC NEG_C POS_C 0
XU_C POS_C NEG_C AVCC 0 OUT_C REF RGP_C RGN_C INA823
R_GC1 RGP_C RGM_C 5.6k
R_GC2 RGM_C RGN_C 5.6k

.save V(POS_D) V(NEG_D) V(OUT_D) V(POS_C) V(NEG_C) V(OUT_C)
.ac dec 50 0.01 1Meg
.end
